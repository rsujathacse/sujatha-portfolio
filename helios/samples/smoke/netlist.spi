* Helios internal sample netlist (demo project only).
* Do not substitute classified analog IP.

.subckt smoke_buffer in out vdd vss
M1 out in vdd vdd pmos w=1u l=0.18u
M2 out in vss vss nmos w=0.5u l=0.18u
.ends
